* Virtual cattle tag: battery + series impedance + reservoir capacitor + TX load
* SIMULATED. RBAT and Cbulk are configurable assumptions, not a selected cell model.
.param VBAT=3.6
.param RBAT=0.25
.param CBULK=4.7e-05
.param I_IDLE=1.75e-06
.param I_TX=0.0453048
.param T_TX=0.12
Vcell source 0 DC {VBAT}
Vsense source battery 0
Rcell battery vtag {RBAT}
Cbulk vtag 0 {CBULK} IC={VBAT}
* One beacon pulse, representative transient only; daily charge is integrated by energy_model.py.
Iload vtag 0 PULSE({I_IDLE} {I_TX} 10m 10u 10u {T_TX} 1s)
.control
set noaskquit
set wr_singlescale
tran 10u 250m 0 10u uic
meas tran vtag_min MIN v(vtag) FROM=10m TO=140m
meas tran battery_peak MAX i(Vsense) FROM=10m TO=140m
quit
.endc
.end
